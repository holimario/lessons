section tt_lib
include "cmn018_gp2a_5v_v1d4.scs" section=tt
include "cmn018_gp2a_5v_v1d4.scs" section=tt_5
include "cmn018_gp2a_5v_v1d4.scs" section=tt_m
include "cmn018_gp2a_5v_v1d4.scs" section=tt_5m
include "cmn018_gp2a_5v_v1d4.scs" section=tt_na
include "cmn018_gp2a_5v_v1d4.scs" section=tt_5vna
include "cmn018_gp2a_5v_v1d4.scs" section=tt_bip
include "cmn018_gp2a_5v_v1d4.scs" section=tt_bip5_rpo
include "cmn018_gp2a_5v_v1d4.scs" section=tt_dio_5
include "cmn018_gp2a_5v_v1d4.scs" section=tt_dio_m
include "cmn018_gp2a_5v_v1d4.scs" section=tt_dio_5m
include "cmn018_gp2a_5v_v1d4.scs" section=tt_dio_dnw
include "cmn018_gp2a_5v_v1d4.scs" section=tt_dio_dnw_5
include "cmn018_gp2a_5v_v1d4.scs" section=tt_res
include "cmn018_gp2a_5v_v1d4.scs" section=tt_disres
include "cmn018_gp2a_5v_v1d4.scs" section=tt_dio
include "cmn018_gp2a_5v_v1d4.scs" section=tt_bbmvar
include "cmn018_gp2a_5v_v1d4.scs" section=tt_bbmvar5
include "cmn018_gp2a_5v_v1d4.scs" section=tt_mim
include "cmn018_gp2a_5v_v1d4.scs" section=tt_rtmom
include "cmn018_gp2a_5v_v1d4.scs" section=tt_fmom
include "cmn018_gp2a_5v_v1d4.scs" section=tt_dio_sbd_mac
parOpt options redefinedparams=ignore
parameters mismatchflag_mos=0
parameters mismatchflag_mos_5=0
parameters mismatchflag_mos_m=0
parameters mismatchflag_mos_5m=0
parameters mismatchflag_mos_na=0
parameters mismatchflag_mos_na5=0
parameters mismatchflag_bip=0
parameters mismatchflag_bip5_rpo=0
parameters mismatchflag_res=0
parameters mismatchflag_disres=0
parameters mismatchflag_cap5=0
parameters mismatchflag_mim=0
parameters mismatchflag_rtmom=0
parameters mismatchflag_fmom=0
endsection tt_lib

section ss_lib
include "cmn018_gp2a_5v_v1d4.scs" section=ss
include "cmn018_gp2a_5v_v1d4.scs" section=ss_5
include "cmn018_gp2a_5v_v1d4.scs" section=ss_m
include "cmn018_gp2a_5v_v1d4.scs" section=ss_5m
include "cmn018_gp2a_5v_v1d4.scs" section=ss_na
include "cmn018_gp2a_5v_v1d4.scs" section=ss_5vna
include "cmn018_gp2a_5v_v1d4.scs" section=ss_bip
include "cmn018_gp2a_5v_v1d4.scs" section=ss_bip5_rpo
include "cmn018_gp2a_5v_v1d4.scs" section=ss_dio_5
include "cmn018_gp2a_5v_v1d4.scs" section=ss_dio_m
include "cmn018_gp2a_5v_v1d4.scs" section=ss_dio_5m
include "cmn018_gp2a_5v_v1d4.scs" section=ss_dio_dnw
include "cmn018_gp2a_5v_v1d4.scs" section=ss_dio_dnw_5
include "cmn018_gp2a_5v_v1d4.scs" section=ss_res
include "cmn018_gp2a_5v_v1d4.scs" section=ss_disres
include "cmn018_gp2a_5v_v1d4.scs" section=ss_dio
include "cmn018_gp2a_5v_v1d4.scs" section=ss_bbmvar
include "cmn018_gp2a_5v_v1d4.scs" section=ss_bbmvar5
include "cmn018_gp2a_5v_v1d4.scs" section=ss_mim
include "cmn018_gp2a_5v_v1d4.scs" section=ss_rtmom
include "cmn018_gp2a_5v_v1d4.scs" section=ss_fmom
include "cmn018_gp2a_5v_v1d4.scs" section=ss_dio_sbd_mac
parOpt options redefinedparams=ignore
parameters mismatchflag_mos=0
parameters mismatchflag_mos_5=0
parameters mismatchflag_mos_m=0
parameters mismatchflag_mos_5m=0
parameters mismatchflag_mos_na=0
parameters mismatchflag_mos_na5=0
parameters mismatchflag_bip=0
parameters mismatchflag_bip5_rpo=0
parameters mismatchflag_res=0
parameters mismatchflag_disres=0
parameters mismatchflag_cap5=0
parameters mismatchflag_mim=0
parameters mismatchflag_rtmom=0
parameters mismatchflag_fmom=0
endsection ss_lib

section ff_lib
include "cmn018_gp2a_5v_v1d4.scs" section=ff
include "cmn018_gp2a_5v_v1d4.scs" section=ff_5
include "cmn018_gp2a_5v_v1d4.scs" section=ff_m
include "cmn018_gp2a_5v_v1d4.scs" section=ff_5m
include "cmn018_gp2a_5v_v1d4.scs" section=ff_na
include "cmn018_gp2a_5v_v1d4.scs" section=ff_5vna
include "cmn018_gp2a_5v_v1d4.scs" section=ff_bip
include "cmn018_gp2a_5v_v1d4.scs" section=ff_bip5_rpo
include "cmn018_gp2a_5v_v1d4.scs" section=ff_dio_5
include "cmn018_gp2a_5v_v1d4.scs" section=ff_dio_m
include "cmn018_gp2a_5v_v1d4.scs" section=ff_dio_5m
include "cmn018_gp2a_5v_v1d4.scs" section=ff_dio_dnw
include "cmn018_gp2a_5v_v1d4.scs" section=ff_dio_dnw_5
include "cmn018_gp2a_5v_v1d4.scs" section=ff_res
include "cmn018_gp2a_5v_v1d4.scs" section=ff_disres
include "cmn018_gp2a_5v_v1d4.scs" section=ff_dio
include "cmn018_gp2a_5v_v1d4.scs" section=ff_bbmvar
include "cmn018_gp2a_5v_v1d4.scs" section=ff_bbmvar5
include "cmn018_gp2a_5v_v1d4.scs" section=ff_mim
include "cmn018_gp2a_5v_v1d4.scs" section=ff_rtmom
include "cmn018_gp2a_5v_v1d4.scs" section=ff_fmom
include "cmn018_gp2a_5v_v1d4.scs" section=ff_dio_sbd_mac
parOpt options redefinedparams=ignore
parameters mismatchflag_mos=0
parameters mismatchflag_mos_5=0
parameters mismatchflag_mos_m=0
parameters mismatchflag_mos_5m=0
parameters mismatchflag_mos_na=0
parameters mismatchflag_mos_na5=0
parameters mismatchflag_bip=0
parameters mismatchflag_bip5_rpo=0
parameters mismatchflag_res=0
parameters mismatchflag_disres=0
parameters mismatchflag_cap5=0
parameters mismatchflag_mim=0
parameters mismatchflag_rtmom=0
parameters mismatchflag_fmom=0
endsection ff_lib

section sf_lib
include "cmn018_gp2a_5v_v1d4.scs" section=sf
include "cmn018_gp2a_5v_v1d4.scs" section=sf_5
include "cmn018_gp2a_5v_v1d4.scs" section=sf_m
include "cmn018_gp2a_5v_v1d4.scs" section=sf_5m
include "cmn018_gp2a_5v_v1d4.scs" section=sf_na
include "cmn018_gp2a_5v_v1d4.scs" section=sf_5vna
include "cmn018_gp2a_5v_v1d4.scs" section=tt_bip
include "cmn018_gp2a_5v_v1d4.scs" section=tt_bip5_rpo
include "cmn018_gp2a_5v_v1d4.scs" section=tt_dio_5
include "cmn018_gp2a_5v_v1d4.scs" section=tt_dio_m
include "cmn018_gp2a_5v_v1d4.scs" section=tt_dio_5m
include "cmn018_gp2a_5v_v1d4.scs" section=tt_dio_dnw
include "cmn018_gp2a_5v_v1d4.scs" section=tt_dio_dnw_5
include "cmn018_gp2a_5v_v1d4.scs" section=tt_res
include "cmn018_gp2a_5v_v1d4.scs" section=tt_disres
include "cmn018_gp2a_5v_v1d4.scs" section=tt_dio
include "cmn018_gp2a_5v_v1d4.scs" section=tt_bbmvar
include "cmn018_gp2a_5v_v1d4.scs" section=tt_bbmvar5
include "cmn018_gp2a_5v_v1d4.scs" section=tt_mim
include "cmn018_gp2a_5v_v1d4.scs" section=tt_rtmom
include "cmn018_gp2a_5v_v1d4.scs" section=tt_fmom
include "cmn018_gp2a_5v_v1d4.scs" section=tt_dio_sbd_mac
parOpt options redefinedparams=ignore
parameters mismatchflag_mos=0
parameters mismatchflag_mos_5=0
parameters mismatchflag_mos_m=0
parameters mismatchflag_mos_5m=0
parameters mismatchflag_mos_na=0
parameters mismatchflag_mos_na5=0
parameters mismatchflag_bip=0
parameters mismatchflag_bip5_rpo=0
parameters mismatchflag_res=0
parameters mismatchflag_disres=0
parameters mismatchflag_cap5=0
parameters mismatchflag_mim=0
parameters mismatchflag_rtmom=0
parameters mismatchflag_fmom=0
endsection sf_lib

section fs_lib
include "cmn018_gp2a_5v_v1d4.scs" section=fs
include "cmn018_gp2a_5v_v1d4.scs" section=fs_5
include "cmn018_gp2a_5v_v1d4.scs" section=fs_m
include "cmn018_gp2a_5v_v1d4.scs" section=fs_5m
include "cmn018_gp2a_5v_v1d4.scs" section=fs_na
include "cmn018_gp2a_5v_v1d4.scs" section=fs_5vna
include "cmn018_gp2a_5v_v1d4.scs" section=tt_bip
include "cmn018_gp2a_5v_v1d4.scs" section=tt_bip5_rpo
include "cmn018_gp2a_5v_v1d4.scs" section=tt_dio_5
include "cmn018_gp2a_5v_v1d4.scs" section=tt_dio_m
include "cmn018_gp2a_5v_v1d4.scs" section=tt_dio_5m
include "cmn018_gp2a_5v_v1d4.scs" section=tt_dio_dnw
include "cmn018_gp2a_5v_v1d4.scs" section=tt_dio_dnw_5
include "cmn018_gp2a_5v_v1d4.scs" section=tt_res
include "cmn018_gp2a_5v_v1d4.scs" section=tt_disres
include "cmn018_gp2a_5v_v1d4.scs" section=tt_dio
include "cmn018_gp2a_5v_v1d4.scs" section=tt_bbmvar
include "cmn018_gp2a_5v_v1d4.scs" section=tt_bbmvar5
include "cmn018_gp2a_5v_v1d4.scs" section=tt_mim
include "cmn018_gp2a_5v_v1d4.scs" section=tt_rtmom
include "cmn018_gp2a_5v_v1d4.scs" section=tt_fmom
include "cmn018_gp2a_5v_v1d4.scs" section=tt_dio_sbd_mac
parOpt options redefinedparams=ignore
parameters mismatchflag_mos=0
parameters mismatchflag_mos_5=0
parameters mismatchflag_mos_m=0
parameters mismatchflag_mos_5m=0
parameters mismatchflag_mos_na=0
parameters mismatchflag_mos_na5=0
parameters mismatchflag_bip=0
parameters mismatchflag_bip5_rpo=0
parameters mismatchflag_res=0
parameters mismatchflag_disres=0
parameters mismatchflag_cap5=0
parameters mismatchflag_mim=0
parameters mismatchflag_rtmom=0
parameters mismatchflag_fmom=0
endsection fs_lib

section mc_lib
include "cmn018_gp2a_5v_v1d4.scs" section=mc
include "cmn018_gp2a_5v_v1d4.scs" section=mc_5
include "cmn018_gp2a_5v_v1d4.scs" section=mc_m
include "cmn018_gp2a_5v_v1d4.scs" section=mc_5m
include "cmn018_gp2a_5v_v1d4.scs" section=mc_na
include "cmn018_gp2a_5v_v1d4.scs" section=mc_5vna
include "cmn018_gp2a_5v_v1d4.scs" section=mc_bip
include "cmn018_gp2a_5v_v1d4.scs" section=mc_bip5_rpo
include "cmn018_gp2a_5v_v1d4.scs" section=tt_dio_5
include "cmn018_gp2a_5v_v1d4.scs" section=tt_dio_m
include "cmn018_gp2a_5v_v1d4.scs" section=tt_dio_5m
include "cmn018_gp2a_5v_v1d4.scs" section=tt_dio_dnw
include "cmn018_gp2a_5v_v1d4.scs" section=tt_dio_dnw_5
include "cmn018_gp2a_5v_v1d4.scs" section=mc_res
include "cmn018_gp2a_5v_v1d4.scs" section=mc_disres
include "cmn018_gp2a_5v_v1d4.scs" section=tt_dio
include "cmn018_gp2a_5v_v1d4.scs" section=mc_bbmvar
include "cmn018_gp2a_5v_v1d4.scs" section=mc_bbmvar5
include "cmn018_gp2a_5v_v1d4.scs" section=mc_mim
include "cmn018_gp2a_5v_v1d4.scs" section=mc_rtmom
include "cmn018_gp2a_5v_v1d4.scs" section=mc_fmom
include "cmn018_gp2a_5v_v1d4.scs" section=tt_dio_sbd_mac
include "cmn018_gp2a_5v_v1d4.scs" section=stat_res
include "cmn018_gp2a_5v_v1d4.scs" section=stat_disres
include "cmn018_gp2a_5v_v1d4.scs" section=stat
include "cmn018_gp2a_5v_v1d4.scs" section=stat_mim
include "cmn018_gp2a_5v_v1d4.scs" section=stat_mom
parOpt options redefinedparams=ignore
parameters mismatchflag_mos=0
parameters mismatchflag_mos_5=0
parameters mismatchflag_mos_m=0
parameters mismatchflag_mos_5m=0
parameters mismatchflag_mos_na=0
parameters mismatchflag_mos_na5=0
parameters mismatchflag_bip=0
parameters mismatchflag_bip5_rpo=0
parameters mismatchflag_res=0
parameters mismatchflag_disres=0
parameters mismatchflag_cap5=0
parameters mismatchflag_mim=0
parameters mismatchflag_rtmom=0
parameters mismatchflag_fmom=0
endsection mc_lib

section mismatch_lib
include "cmn018_gp2a_5v_v1d4.scs" section=tt
include "cmn018_gp2a_5v_v1d4.scs" section=tt_5
include "cmn018_gp2a_5v_v1d4.scs" section=tt_m
include "cmn018_gp2a_5v_v1d4.scs" section=tt_5m
include "cmn018_gp2a_5v_v1d4.scs" section=tt_na
include "cmn018_gp2a_5v_v1d4.scs" section=tt_5vna
include "cmn018_gp2a_5v_v1d4.scs" section=tt_bip
include "cmn018_gp2a_5v_v1d4.scs" section=tt_bip5_rpo
include "cmn018_gp2a_5v_v1d4.scs" section=tt_dio_5
include "cmn018_gp2a_5v_v1d4.scs" section=tt_dio_m
include "cmn018_gp2a_5v_v1d4.scs" section=tt_dio_5m
include "cmn018_gp2a_5v_v1d4.scs" section=tt_dio_dnw
include "cmn018_gp2a_5v_v1d4.scs" section=tt_dio_dnw_5
include "cmn018_gp2a_5v_v1d4.scs" section=tt_res
include "cmn018_gp2a_5v_v1d4.scs" section=tt_disres
include "cmn018_gp2a_5v_v1d4.scs" section=tt_dio
include "cmn018_gp2a_5v_v1d4.scs" section=tt_bbmvar
include "cmn018_gp2a_5v_v1d4.scs" section=tt_bbmvar5
include "cmn018_gp2a_5v_v1d4.scs" section=tt_mim
include "cmn018_gp2a_5v_v1d4.scs" section=tt_rtmom
include "cmn018_gp2a_5v_v1d4.scs" section=tt_fmom
include "cmn018_gp2a_5v_v1d4.scs" section=tt_dio_sbd_mac
include "cmn018_gp2a_5v_v1d4.scs" section=stat_mis
include "cmn018_gp2a_5v_v1d4.scs" section=stat_mis_5
include "cmn018_gp2a_5v_v1d4.scs" section=stat_mis_m
include "cmn018_gp2a_5v_v1d4.scs" section=stat_mis_5m
include "cmn018_gp2a_5v_v1d4.scs" section=stat_mis_na
include "cmn018_gp2a_5v_v1d4.scs" section=stat_mis_5vna
include "cmn018_gp2a_5v_v1d4.scs" section=stat_mis_bip
include "cmn018_gp2a_5v_v1d4.scs" section=stat_mis_bip5_rpo
include "cmn018_gp2a_5v_v1d4.scs" section=stat_mis_res
include "cmn018_gp2a_5v_v1d4.scs" section=stat_mis_disres
include "cmn018_gp2a_5v_v1d4.scs" section=stat_mis_bbmvar5
include "cmn018_gp2a_5v_v1d4.scs" section=stat_mis_mim
include "cmn018_gp2a_5v_v1d4.scs" section=stat_mis_rtmom
include "cmn018_gp2a_5v_v1d4.scs" section=stat_mis_fmom
parOpt options redefinedparams=ignore
parameters mismatchflag_mos=1
parameters mismatchflag_mos_5=1
parameters mismatchflag_mos_m=1
parameters mismatchflag_mos_5m=1
parameters mismatchflag_mos_na=1
parameters mismatchflag_mos_na5=1
parameters mismatchflag_bip=1
parameters mismatchflag_bip5_rpo=1
parameters mismatchflag_res=1
parameters mismatchflag_disres=1
parameters mismatchflag_cap5=1
parameters mismatchflag_mim=1
parameters mismatchflag_rtmom=1
parameters mismatchflag_fmom=1
endsection mismatch_lib
