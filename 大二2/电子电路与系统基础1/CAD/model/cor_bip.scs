library bip_cor

section ff_bip
include "cmn018_gp2a_5v_v1d4.scs" section = ff_bip
endsection ff_bip

section ss_bip
include "cmn018_gp2a_5v_v1d4.scs" section = ss_bip
endsection ss_bip

section tt_bip
include "cmn018_gp2a_5v_v1d4.scs" section = tt_bip
endsection tt_bip

endlibrary bip_cor
